addrmap test 
{
   name = "test";
   desc = "test V2.0";
   default regwidth = 32;
   default hw=rw;
   reg cfg_reg {
       name="cfg_reg";
       field{
           sw=r;
           desc="Reserved";
       }reserved[31:20]=4'h0;
       field{
           sw=r;
           onread=rclr;
           desc="Config port3 roles";
       }port3_role[19:16]=4'h1;
       field{
           sw=r;
           onread=rset;
           desc="Config port2 roles";
       }port2_role[15:12]=4'h2;
       field{
           sw=w;
           desc="Config port1 roles";
       }port1_role[11:8]=4'h3;
       field{
           sw=w;
           onwrite=wclr;
           desc="Config port0 roles";
       }port0_role[7:4]=4'h4;
       field{
           sw=w1;
           desc="Config Switch roles";
       }Switch_role[3:0]=4'h5;
   };
   reg status_reg {
       name="status_reg";
       field{
           sw=rw;
           onwrite=woclr;
           desc="";
       }Reserved[31:5]=27'h0;
       field{
           sw=rw;
           onwrite=woset;
           desc="0x0:domian 0 0x4:donmian 1";
       }Sync_ctrl[4:1]=4'h0;
       field{
           sw=rw;
           onwrite=wzc;
           desc="Status";
       }Sync_state[0:0]=1'h0;
   };
   reg error_reg {
       name="error_reg";
       field{
           sw=rw;
           onread=rclr;
           desc="Reserved";
       }Reserved[31:3]=29'h0;
       field{
           sw=rw;
           onread=rclr;
           onwrite=woset;
           desc="-";
       }rate_update_error[2:2]=1'h0;
       field{
           sw=rw;
           onread=rset;
           desc="-";
       }pdelay_update_error[1:1]=1'h0;
   };
cfg_reg cfg_reg @ 0x0000;
status_reg status_reg @ 0x0004;
error_reg error_reg @ 0x0008;
};
